ADE simulation setup
Run mode: Single Run, Sweeps and Corners
