ADE simulation setup
Run mode: Single Run, Sweeps and Corners
Tests:
  bliss:delay_line_tb_delay:1: bliss/delay_line_tb_delay/schematic, simulator spectre
