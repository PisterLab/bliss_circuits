ADE simulation setup
Run mode: Single Run, Sweeps and Corners
Tests:
  bliss:dll_tb_phases:1: bliss/dll_tb_phases/schematic, simulator spectre
